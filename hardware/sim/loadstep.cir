* +5V load-step transient: confirm bulk caps hold VCC2 during a DMX-driver current burst
.model SS54 D(Is=2e-5 N=1.0 Rs=0.13 Cjo=300p)
Vsrc src 0 DC 5.0                 ; PoE-regulated 5.0V (worst realistic source)
Rptc src a 0.025
Dor  a p5v SS54
Cor  p5v 0 22u                    ; C29 OR bulk
Cbuckin p5v 0 22u                 ; C16 buck input
Ibuck p5v 0 DC 0.40
Rfb1 p5v dmx 0.10                 ; FB1
Cdmx dmx 0 20u                    ; C21+C26 (10u each) at the B0505S inputs
* DMX-side load steps 0.30 -> 0.55A (both drivers switching) in 1us, back after 200us
Idmx dmx 0 PWL(0 0.30 1m 0.30 1.001m 0.55 1.2m 0.55 1.201m 0.30 3m 0.30)
.control
tran 5u 3m
meas tran vmin MIN v(dmx) from=0.9m to=1.5m
meas tran vsettle FIND v(dmx) AT=2.9m
echo "v(dmx) is B0505S input ~ VCC2; min during the 0.55A burst should stay >= 4.5V"
.endc
.end
