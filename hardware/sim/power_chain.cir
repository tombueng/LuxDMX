* LuxDMX +5V power chain DC validation: source -> PTC -> TPS2116 ideal-diode mux -> +5V -> FB1 -> B0505S input
* OR-ing element is now the TPS2116 power mux (U9), not a Schottky. RDSON ~= 40 mOhm typ (65 mOhm max
* over temp). Replaces the old SS54 (~0.40V Vf), which dropped +5V below the ISO3086 VCC2 4.5V min on USB.
* Worst case here: both B0505S at full input + buck/logic, ~0.8A total through the mux.
.param Rmux=0.040        ; TPS2116 RDSON typ (set 0.065 for max-over-temp check)
Vsrc src 0 DC 5.0
Rptc src a 0.025         ; PTC F1 (25 mOhm)
Rormux a p5v {Rmux}      ; TPS2116 mux pass-FET (only the higher input conducts)
Ibuck p5v 0 DC 0.40     ; buck + logic load on +5V (does NOT go through FB1)
Rfb1 p5v dmx 0.10       ; ferrite FB1 (100 mOhm) to the DMX iso DC-DC inputs
Idmx  dmx 0 DC 0.40     ; both B0505S input current through FB1
.control
echo "== USB power via TPS2116: sweep VBUS 4.70..5.25 (load 0.8A total) =="
dc Vsrc 4.70 5.25 0.05
print v(p5v) v(dmx)
echo "== v(dmx) ~= B0505S input ~= VCC2 rail; ISO3086 VCC2 min = 4.5V. Mux drop ~32mV vs 0.40V diode =="
.endc
.end
